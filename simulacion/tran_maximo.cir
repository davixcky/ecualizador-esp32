* tran_maximo — ecualizador de tres bandas (generado por herramientas/simulacion.py)
.include lm324.lib
V5 P5V 0 5
V33 P3V3 0 3.3
R1 P3V3 P3_3VA 10
C1 P3_3VA 0 100u
C2 P3_3VA 0 100n
C3 P5V 0 470u
C4 P5V 0 100n
C5 P5V 0 100n
C6 P5V 0 100n
C7 P5V 0 100n
R2 P3_3VA VDIV 10k
R3 VDIV 0 10k
C8 VDIV 0 10u
R4 IN_L MIX 10k
R5 IN_R MIX 10k
RV1a MIX NIVEL 1
RV1b NIVEL 0 9999
C9 NIVEL PRE_IN 1u
R6 PRE_IN VREF 100k
R7 PRE_FB PRE 22k
R8 PRE_FB PRE_G 10k
C10 PRE_G VREF 10u
R9 PRE LB1 10k
R10 LB1 LB2 10k
C11 LB1 GRAVES 100n
C12 LB2 VREF 47n
C13 PRE MH1 10n
C14 MH1 MH2 10n
R11 MH1 MED_HP 27k
R12 MH2 VREF 56k
R13 MED_HP ML1 10k
R14 ML1 ML2 10k
C15 ML1 MEDIOS 10n
C16 ML2 VREF 4.7n
C17 PRE AH1 10n
C18 AH1 AH2 10n
R15 AH1 AGUDOS 2.7k
R16 AH2 VREF 5.6k
RV2a GRAVES G_W 1
RV2b G_W VREF 9999
RV3a MEDIOS M_W 1
RV3b M_W VREF 9999
RV4a AGUDOS A_W 1
RV4b A_W VREF 9999
R17 M_W INV_N 47k
R18 INV_N M_INV 47k
R19 G_W SUM_N 47k
R20 M_INV SUM_N 47k
R21 A_W SUM_N 47k
R22 SUM_N EQ_OUT 100k
C19 EQ_OUT OUT_AC 10u
R23 OUT_AC LINEA 100
R24 LINEA 0 47k
RV5a LINEA AMP_IN 5000
RV5b AMP_IN 0 5000
R25 EQ_OUT AA1 10k
R26 AA1 AA2 10k
C20 AA1 ADC_FFT_RAW 4.7n
C21 AA2 VREF 2.2n
D1 DO_G DET_G D1N4148
C22 DET_G VREF 100n
R27 DET_G VREF 220k
D2 DO_M DET_M D1N4148
C23 DET_M VREF 100n
R28 DET_M VREF 220k
D3 DO_A DET_A D1N4148
C24 DET_A VREF 100n
R29 DET_A VREF 220k
R33 ADC_G_RAW ADC_G 10k
R34 ADC_G VREF 10k
R35 ADC_M_RAW ADC_M 10k
R36 ADC_M VREF 10k
R37 ADC_A_RAW ADC_A 10k
R38 ADC_A VREF 10k
R39 ADC_FFT_RAW ADC_FFT 10k
R40 ADC_FFT VREF 10k
XU1A VDIV VREF P5V 0 VREF LM324
XU1B PRE_IN PRE_FB P5V 0 PRE LM324
XU1C LB2 GRAVES P5V 0 GRAVES LM324
XU1D MH2 MED_HP P5V 0 MED_HP LM324
XU2A ML2 MEDIOS P5V 0 MEDIOS LM324
XU2B AH2 AGUDOS P5V 0 AGUDOS LM324
XU2C VREF SUM_N P5V 0 EQ_OUT LM324
XU2D AA2 ADC_FFT_RAW P5V 0 ADC_FFT_RAW LM324
XU3A G_W DET_G P5V 0 DO_G LM324
XU3B DET_G ADC_G_RAW P5V 0 ADC_G_RAW LM324
XU3C M_W DET_M P5V 0 DO_M LM324
XU3D DET_M ADC_M_RAW P5V 0 ADC_M_RAW LM324
XU4A A_W DET_A P5V 0 DO_A LM324
XU4B DET_A ADC_A_RAW P5V 0 ADC_A_RAW LM324
XU4C VREF INV_N P5V 0 M_INV LM324
XU4D VREF U4D_OUT P5V 0 U4D_OUT LM324
VIN IN_L 0 SIN(0 0.11 1000)
Rin_r IN_R IN_L 1m
Ramp AMP_IN 0 20k
Radc_ADC_G ADC_G 0 10Meg
Radc_ADC_M ADC_M 0 10Meg
Radc_ADC_A ADC_A 0 10Meg
Radc_ADC_FFT ADC_FFT 0 10Meg
.nodeset v(AA1)=1.65 v(AA2)=1.65 v(ADC_A)=1.65 v(ADC_A_RAW)=1.65 v(ADC_FFT)=1.65 v(ADC_FFT_RAW)=1.65 v(ADC_G)=1.65 v(ADC_G_RAW)=1.65 v(ADC_M)=1.65 v(ADC_M_RAW)=1.65 v(AGUDOS)=1.65 v(AH1)=1.65 v(AH2)=1.65 v(A_W)=1.65 v(DET_A)=1.65 v(DET_G)=1.65 v(DET_M)=1.65 v(EQ_OUT)=1.65 v(GRAVES)=1.65 v(G_W)=1.65 v(INV_N)=1.65 v(LB1)=1.65 v(LB2)=1.65 v(MEDIOS)=1.65 v(MED_HP)=1.65 v(MH1)=1.65 v(MH2)=1.65 v(ML1)=1.65 v(ML2)=1.65 v(M_INV)=1.65 v(M_W)=1.65 v(OUT_AC)=1.65 v(PRE)=1.65 v(PRE_FB)=1.65 v(PRE_G)=1.65 v(PRE_IN)=1.65 v(SUM_N)=1.65 v(U4D_OUT)=1.65 v(VDIV)=1.65 v(VREF)=1.65
.model D1N4148 D(IS=2.52n RS=0.568 N=1.752 CJO=4p M=0.4 TT=20n BV=100 IBV=100u)
.tran 2e-06 0.05 0.0 2e-06
.control
set wr_singlescale
set wr_vecnames
run
wrdata tran_maximo.dat v(ADC_M) v(ADC_M_RAW) v(EQ_OUT) v(ADC_FFT) v(ADC_FFT_RAW) v(PRE) v(PRE_IN) v(LB2) v(MH2) v(ML2) v(AH2) v(AA2) v(G_W) v(M_W) v(A_W) v(VREF)
.endc
.end
