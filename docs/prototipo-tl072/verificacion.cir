* Prototipo TL072: comprobacion lineal ideal, no macromodelo TL072
Vin ENTRADA 0 AC 1
C1 ENTRADA IN 1u
R1 IN 0 100k
R2 PRE FB 22k
R3 FB 0 10k
R4 PRE L1 10k
R5 L1 L2 10k
C2 L1 GRAVES 100n
C3 L2 0 47n
C4 PRE H1 10n
C5 H1 H2 10n
R6 H1 MED_HP 27k
R7 H2 0 56k
R8 MED_HP M1 10k
R9 M1 M2 10k
C6 M1 MEDIOS 10n
C7 M2 0 4.7n
C8 PRE A1 10n
C9 A1 A2 10n
R10 A1 AGUDOS 2.7k
R11 A2 0 5.6k
R12 MW INV 47k
R13 INV MI 47k
R14 GW SUM 47k
R15 MI SUM 47k
R16 AW SUM 47k
R17 SUM EQ 100k
C10 EQ AC 1u
R18 AC SALIDA 100
R19 SALIDA 0 47k
E0 PRE 0 IN FB 1e6
E1 GRAVES 0 L2 GRAVES 1e6
E2 MED_HP 0 H2 MED_HP 1e6
E3 MEDIOS 0 M2 MEDIOS 1e6
E4 AGUDOS 0 A2 AGUDOS 1e6
E5 MI 0 0 INV 1e6
E6 EQ 0 0 SUM 1e6
E7 RESERVA 0 0 RESERVA 1e6
RPG1 GRAVES GW 5k
RPG2 GW 0 5k
RPM1 MEDIOS MW 5k
RPM2 MW 0 5k
RPA1 AGUDOS AW 5k
RPA2 AW 0 5k
.control
set wr_singlescale
set wr_vecnames
ac dec 100 10 100000
let g=mag(v(GRAVES))
let m=mag(v(MEDIOS))
let a=mag(v(AGUDOS))
let salida_mag=mag(v(SALIDA))
wrdata /home/davixcky/dev/.personal/electronica/ecualizador-esp32/docs/prototipo-tl072/respuesta.txt g m a salida_mag
quit
.endc
.end
